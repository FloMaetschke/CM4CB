|   This file is an IBIS representation of the   |
|   Microchip Technology   |
|   KSZ9567S   |
|=================== Header Section -------------------------------------------|
[IBIS Ver]   4.0
[File Name]   ksz9567s.ibs
[File Rev]   1.0
[Date]   11 Sept 2017 | Last modified
|   11 Sept 2017 | Created
[Source]   From SPICE model at Microchip Technology
[Notes]
[Disclaimer]   Microchip herby grants the user of this IBIS model a
|   non-exclusive, non-transferrable license to use this
|   IBIS model under the following terms. Before using this
|   this IBIS model, the user should read this license.
|   If the user does not accept these terms. the
|   IBIS model should be returned to Microchip within 30
|   days.
|   The user is granted this license only to use the IBIS
|   model and is not granted rights to sell, load, rent,
|   lease or license the IBIS model in whole or in part, or
|   in modified form to anyone other than the user. User may
|   modify the IBIS model to suit its specific applications
|   but rights to derivative works and such
|   modifications shall belong to Microchip.
|   The IBIS model is provided on an "AS IS" basis
|   and Microchip makes no warranty with respect to the
|   information contained herein. Microchip DISCLAIMS
|   AND CUSTOMER WAIVES ALL WARRANTIES, EXPRESS OR
|   IMPLIED, INCLUDING WARRANTIES OF MERCHANTABILITY
|   OR FITNESS FOR A PARTICULAR PURPOSE. The entire
|   risk as to quality and performance is with the
|   Customer. ACCORDINGLY, IN NO EVENT SHALL THE
|   COMPANY BE LIABLE FOR ANY DAMAGE, WHETHER IN
|   CONTRACT OR TORT, INCLUDING ANY LOST PROFITS
|   OR OTHER INCIDENTAL, CONSEQUENTIAL, EXEMPLARY,
|   OR PUNITIVE DAMAGES ARISING OUT OF THE USE OR
|   APPLICATION OF THE IBIS model provided in this
|   package. Further, Microchip reserves the right to
|   make changes without notice to any product
|   herein to improve reliability, function, or
|   design. Microchip does not convey any license under
|   patent rights or any other intellectual
|   property rights, including those of third parties.
|   Microchip is not obligated to provide maintaince
|   or support for the licensed IBIS model.
[Copyright]   Copyright (C)2017, Microchip Technology, All Rights Reserved
|------------------- End of Header Section ====================================|
|=================== Component Section ----------------------------------------|
[Component]   KSZ9567S
[Manufacturer]  Microchip Technology
[Package]
|   typ   min   max
R_pkg   0.300Ohm   0.253Ohm   0.403Ohm
L_pkg   4.000nH   3.080nH   5.050nH
C_pkg   0.500pF   0.409pF   0.718pF
[Pin] signal_name   model_name   R_pin   L_pin   C_pin
  1   TXRX1P_A   NC   0.346   4.550nH   0.607pF
  2   TXRX1M_A   NC   0.339   3.940nH   0.636pF
  3   AVDDL   POWER   NA   NA   NA
  4   TXRX1P_B   NC   0.327   4.030nH   0.568pF
  5   TXRX1M_B   NC   0.323   4.140nH   0.552pF
  6   TXRX1P_C   NC   0.313   4.110nH   0.526pF
  7   TXRX1M_C   NC   0.301   3.950nH   0.505pF
  8   TXRX1P_D   NC   0.304   3.870nH   0.496pF
  9   TXRX1M_D   NC   0.296   3.380nH   0.492pF
 10   AVDDH   POWER   NA   NA   NA
 11   DVDDL   POWER   NA   NA   NA
 12   TXRX2P_A   NC   0.269   3.210nH   0.437pF
 13   TXRX2M_A   NC   0.260   3.150nH   0.427pF
 14   AVDDL   POWER   NA   NA   NA
 15   TXRX2P_B   NC   0.260   3.140nH   0.433pF
 16   TXRX2M_B   NC   0.259   3.370nH   0.421pF
 17   TXRX2P_C   NC   0.258   3.390nH   0.419pF
 18   TXRX2M_C   NC   0.254   3.110nH   0.438pF
 19   AVDDL   POWER   NA   NA   NA
 20   TXRX2P_D   NC   0.253   3.110nH   0.418pF
 21   TXRX2M_D   NC   0.258   3.120nH   0.421pF
 22   AVDDH   POWER   NA   NA   NA
 23   DVDDL   POWER   NA   NA   NA
 24   TXRX3P_A   NC   0.278   3.310nH   0.465pF
 25   TXRX3M_A   NC   0.285   3.700nH   0.473pF
 26   TXRX3P_B   NC   0.283   3.800nH   0.481pF
 27   TXRX3M_B   NC   0.296   3.920nH   0.499pF
 28   TXRX3P_C   NC   0.302   3.900nH   0.525pF
 29   TXRX3M_C   NC   0.312   3.660nH   0.573pF
 30   AVDDL   POWER   NA   NA   NA
 31   TXRX3P_D   NC   0.311   3.800nH   0.590pF
 32   TXRX3M_D   NC   0.317   4.380nH   0.583pF
 33   AVDDH   POWER   NA   NA   NA
 34   TXRX4P_A   NC   0.403   4.390nH   0.718pF
 35   TXRX4M_A   NC   0.389   4.160nH   0.700pF
 36   AVDDL   POWER   NA   NA   NA
 37   TXRX4P_B   NC   0.376   4.190nH   0.650pF
 38   TXRX4M_B   NC   0.358   4.420nH   0.601pF
 39   TXRX4P_C   NC   0.350   4.300nH   0.577pF
 40   TXRX4M_C   NC   0.339   3.790nH   0.571pF
 41   AVDDL   POWER   NA   NA   NA
 42   TXRX4P_D   NC   0.323   3.710nH   0.513pF
 43   TXRX4M_D   NC   0.319   3.590nH   0.491pF
 44   AVDDH   POWER   NA   NA   NA
 45   DVDDL   POWER   NA   NA   NA
 46   GND   GND   NA   NA   NA
 47   GND   GND   NA   NA   NA
 48   TX_CLK/REFCLKI6   IO8_selector   0.324   3.800nH   0.479pF
 49   TX_EN6/TX_CTL6   INPUT_selector   0.300   3.980nH   0.482pF
 50   TX_ER6   INPUT_selector   0.291   3.990nH   0.474pF
 51   COL6   IO8_selector   0.288   3.850nH   0.458pF
 52   TXD6_3   INPUT_selector   0.286   3.830nH   0.450pF
 53   TXD6_2   INPUT_selector   0.279   3.880nH   0.449pF
 54   TXD6_1   INPUT_selector   0.278   3.780nH   0.459pF
 55   TXD6_0   INPUT_selector   0.283   3.350nH   0.476pF
 56   DVDDL   POWER   NA   NA   NA
 57   RX_CLK6/REFCLKO6   IO24_selector   0.286   3.430nH   0.481pF
 58   RXDV6/CRSDV6/RXCTL6   IO24_selector   0.285   3.890nH   0.489pF
 59   RX_ER6   IO24_selector   0.293   3.970nH   0.503pF
 60   CRS6   IO8_selector   0.308   3.610nH   0.526pF
 61   VDDIO   POWER   NA   NA   NA
 62   RXD6_3   IO24_selector   0.318   3.760nH   0.579pF
 63   RXD6_2   IO24_selector   0.317   4.470nH   0.614pF
 64   RXD6_1   IO24_selector   0.321   4.810nH   0.615pF
 65   RXD6_0   IO24_selector   0.315   5.020nH   0.595pF
 66   DVDDL   POWER   NA   NA   NA
 67   IBA   INPUT_selector   0.263   3.110nH   0.437pF
 68   VDDIO   POWER   NA   NA   NA
 69   GND   GND   NA   NA   NA
 70   DVDDL   POWER   NA   NA   NA
 71   VDDLS   POWER   NA   NA   NA
 72   VDDHS   POWER   NA   NA   NA
 73   NC   NC   NA   NA   NA
 74   NC   NC   NA   NA   NA
 75   GND   GND   NA   NA   NA
 76   S_REXT   NC   NA   NA   NA
 77   GND   GND   NA   NA   NA
 78   S_IN7M   NC   NA   NA   NA
 79   S_IN7P   NC   NA   NA   NA
 80   GND   GND   NA   NA   NA
 81   S_OUT7P   NC   NA   NA   NA
 82   S_OUT7M   NC   NA   NA   NA
 83   VDDHS   POWER   NA   NA   NA
 84   VDDLS   POWER   NA   NA   NA
 85   LED4_0   IO8_selector   0.269   3.200nH   0.420pF
 86   LED4_1   IO8_selector   0.267   3.080nH   0.442pF
 87   DVDDL   POWER   NA   NA   NA
 88   LED3_0   IO8_selector   0.276   3.300nH   0.472pF
 89   LED3_1   IO8_selector   0.279   3.840nH   0.460pF
 90   GPIO_1   IO8_selector   0.273   3.810nH   0.457pF
 91   LED2_0   IO8_selector   0.270   4.120nH   0.463pF
 92   LED2_1   IO8_selector   0.276   4.310nH   0.495pF
 93   PME_N   IO8_selector   0.281   4.480nH   0.523pF
 94   INTRP_N   IO8_selector   0.286   4.630nH   0.531pF
 95   SYNCLKO   IO24_selector   0.310   4.910nH   0.602pF
 96   RESET_N   INPUT_selector   0.329   5.050nH   0.627pF
 97   SDO   IO8_selector   0.351   4.700nH   0.647pF
 98   SDI/SDA/MDIO   IO8_selector   0.351   3.910nH   0.662pF
 99   VDDIO   POWER   NA   NA   NA
100   SCS_N   INPUT_selector   0.337   3.760nH   0.579pF
101   SCL/MDC   INPUT_selector   0.325   4.070nH   0.539pF
102   LED5_0   IO8_selector   0.320   4.010nH   0.519pF
103   LED5_1   IO8_selector   0.310   3.570nH   0.510pF
104   DVDDL   POWER   NA   NA   NA
105   LED1_0   IO8_selector   0.295   3.440nH   0.478pF
106   LED1_1   IO8_selector   0.295   3.610nH   0.447pF
107   GND   GND   NA   NA   NA
108   NC   NC   0.283   3.280nH   0.443pF
109   GND   GND   NA   NA   NA
110   DVDDL   POWER   NA   NA   NA
111   AVDDH   POWER   NA   NA   NA
112   TXRX5P_A   NC   0.277   3.310nH   0.426pF
113   TXRX5M_A   NC   0.274   3.240nH   0.442pF
114   AVDDL   POWER   NA   NA   NA
115   TXRX5P_B   NC   0.276   3.320nH   0.456pF
116   TXRX5M_B   NC   0.280   3.620nH   0.456pF
117   TXRX5P_C   NC   0.284   3.660nH   0.470pF
118   TXRX5M_C   NC   0.287   3.440nH   0.485pF
119   AVDDL   POWER   NA   NA   NA
120   TXRX5P_D   NC   0.295   3.410nH   0.519pF
121   TXRX5M_D   NC   0.307   3.540nH   0.533pF
122   AVDDH   POWER   NA   NA   NA
123   GND   GND   NA   NA   NA
124   AVDDL   POWER   NA   NA   NA
125   XO   NC   0.332   3.880nH   0.583pF
126   XI   NC   0.330   4.360nH   0.588pF
127   ISET   NC   0.317   3.980nH   0.581pF
128   AVDDH   POWER   NA   NA   NA
|------------------- End of Component Section =================================|
[Model Selector]   IO8_selector
IO8_1V8   VDDIO = 1.8V
IO8_2V5   VDDIO = 2.5V
IO8_3V3   VDDIO = 3.3V
[Model Selector]   INPUT_selector
INPUT_1V8   VDDIO = 1.8V
INPUT_2V5   VDDIO = 2.5V
INPUT_3V3   VDDIO = 3.3V
[Model Selector]   IO24_selector
IO24_1V8   VDDIO = 1.8V
IO24_2V5   VDDIO = 2.5V
IO24_3V3   VDDIO = 3.3V
| Models and submodels in the file (9): IO8_1V8 (I/O), IO8_2V5 (I/O), IO8_3V3 (I/O), INPUT_1V8 (Input), INPUT_2V5 (Input), INPUT_3V3 (Input), IO24_1V8 (I/O), IO24_2V5 (I/O), IO24_3V3 (I/O)
